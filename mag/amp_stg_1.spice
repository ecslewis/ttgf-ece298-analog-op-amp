* NGSPICE file created from amp_stg_1.ext - technology: gf180mcuD

.subckt pfet_03v3_W5SFVU a_n452_n792# a_n52_n700# a_452_n700# a_52_n792# a_n556_n700#
+ a_n956_n792# a_556_n792# a_956_n700# a_n1044_n700#
X0 a_n556_n700# a_n956_n792# a_n1044_n700# w_n1206_n910# pfet_03v3 ad=1.82p pd=7.52u as=3.08p ps=14.88u w=7u l=2u
X1 a_n52_n700# a_n452_n792# a_n556_n700# w_n1206_n910# pfet_03v3 ad=1.82p pd=7.52u as=1.82p ps=7.52u w=7u l=2u
X2 a_452_n700# a_52_n792# a_n52_n700# w_n1206_n910# pfet_03v3 ad=1.82p pd=7.52u as=1.82p ps=7.52u w=7u l=2u
X3 a_956_n700# a_556_n792# a_452_n700# w_n1206_n910# pfet_03v3 ad=3.08p pd=14.88u as=1.82p ps=7.52u w=7u l=2u
.ends

.subckt nfet_03v3_D3XTXL a_n1182_n586#
X0 a_n556_n400# a_n956_n492# a_n1044_n400# a_n1182_n586# nfet_03v3 ad=1.04p pd=4.52u as=1.76p ps=8.88u w=4u l=2u
X1 a_n52_n400# a_n452_n492# a_n556_n400# a_n1182_n586# nfet_03v3 ad=1.04p pd=4.52u as=1.04p ps=4.52u w=4u l=2u
X2 a_452_n400# a_52_n492# a_n52_n400# a_n1182_n586# nfet_03v3 ad=1.04p pd=4.52u as=1.04p ps=4.52u w=4u l=2u
X3 a_956_n400# a_556_n492# a_452_n400# a_n1182_n586# nfet_03v3 ad=1.76p pd=8.88u as=1.04p ps=4.52u w=4u l=2u
.ends

.subckt nfet_03v3_8EAYTP a_n942_n986#
X0 a_716_n800# a_436_n892# a_332_n800# a_n942_n986# nfet_03v3 ad=3.52p pd=16.88u as=2.08p ps=8.52u w=8u l=1.4u
X1 a_n436_n800# a_n716_n892# a_n804_n800# a_n942_n986# nfet_03v3 ad=2.08p pd=8.52u as=3.52p ps=16.88u w=8u l=1.4u
X2 a_332_n800# a_52_n892# a_n52_n800# a_n942_n986# nfet_03v3 ad=2.08p pd=8.52u as=2.08p ps=8.52u w=8u l=1.4u
X3 a_n52_n800# a_n332_n892# a_n436_n800# a_n942_n986# nfet_03v3 ad=2.08p pd=8.52u as=2.08p ps=8.52u w=8u l=1.4u
.ends

.subckt nfet_03v3_SSV5GB a_n558_n986#
X0 a_332_n800# a_52_n892# a_n52_n800# a_n558_n986# nfet_03v3 ad=3.52p pd=16.88u as=2.08p ps=8.52u w=8u l=1.4u
X1 a_n52_n800# a_n332_n892# a_n420_n800# a_n558_n986# nfet_03v3 ad=2.08p pd=8.52u as=3.52p ps=16.88u w=8u l=1.4u
.ends

.subckt amp_stg_1 VDD vout vbias_1 vbias_2 vn vp vbias_tail VSS
XM10 M10/a_n452_n792# M10/a_n52_n700# M10/a_452_n700# M10/a_52_n792# M10/a_n556_n700#
+ M10/a_n956_n792# M10/a_556_n792# M10/a_956_n700# M10/a_n1044_n700# pfet_03v3_W5SFVU
XM2 M2/a_n452_n792# M2/a_n52_n700# M2/a_452_n700# M2/a_52_n792# M2/a_n556_n700# M2/a_n956_n792#
+ M2/a_556_n792# M2/a_956_n700# M2/a_n1044_n700# pfet_03v3_W5SFVU
XM4 VSUBS nfet_03v3_D3XTXL
XM3 VSUBS nfet_03v3_8EAYTP
XM5 VSUBS nfet_03v3_D3XTXL
Xnfet_03v3_SSV5GB_0 VSUBS nfet_03v3_SSV5GB
Xnfet_03v3_SSV5GB_1 VSUBS nfet_03v3_SSV5GB
Xnfet_03v3_SSV5GB_2 VSUBS nfet_03v3_SSV5GB
XM8 M8/a_n452_n792# M8/a_n52_n700# M8/a_452_n700# M8/a_52_n792# M8/a_n556_n700# M8/a_n956_n792#
+ M8/a_556_n792# M8/a_956_n700# M8/a_n1044_n700# pfet_03v3_W5SFVU
XM9 m1_10468_n5448# m1_10136_n5738# m1_10642_n6038# m1_11436_n5450# m1_10642_n6038#
+ m1_10468_n5448# m1_11436_n5450# m1_10136_n5738# m1_10136_n5738# pfet_03v3_W5SFVU
Xnfet_03v3_SSV5GB_3 VSUBS nfet_03v3_SSV5GB
.ends
